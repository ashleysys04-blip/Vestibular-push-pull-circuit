* [L1b] Vestibular push-pull stage - hysteretic switch version
.param V_bias = 0.5        ; resting discharge bias (V)
.param R_g    = 100k       ; finite gate-node impedance
.param C_g    = 100n       ; membrane capacitance -> tau_m = 10 ms

VDD VDD 0 1.8
V_head IN 0 SINE(0 0.2 1)

* --- push-pull drive ---
B_src_L GL_SRC 0 V = {V_bias} + V(IN)
B_src_R GR_SRC 0 V = {V_bias} - V(IN)
R_gL GL_SRC GATE_L {R_g}
R_gR GR_SRC GATE_R {R_g}
C_gL GATE_L 0 {C_g}
C_gR GATE_R 0 {C_g}

* --- latch core: hysteretic switch (Vt +/- Vh = 0.45 / 0.35 V) ---
S_lat_L DRAIN_L 0 GATE_L 0 STLSW
S_lat_R DRAIN_R 0 GATE_R 0 STLSW
R_load_L VDD DRAIN_L 1k
R_load_R VDD DRAIN_R 1k
.model STLSW SW(Ron=500 Roff=50k Vt=0.40 Vh=0.05)

* --- spike sense: DRAIN pulled low = latched ---
B_spk_L SPIKE_L 0 V = 0.9*(1-tanh(20*(V(DRAIN_L)-1.1)))
B_spk_R SPIKE_R 0 V = 0.9*(1-tanh(20*(V(DRAIN_R)-1.1)))

* --- self-reset (AHP) and commissural cross-inhibition ---
S_ahp_L GATE_L 0 SPIKE_L 0 INHSW
S_ahp_R GATE_R 0 SPIKE_R 0 INHSW
S_com_R GATE_R 0 SPIKE_L 0 INHSW
S_com_L GATE_L 0 SPIKE_R 0 INHSW
.model INHSW SW(Ron=10k Roff=1G Vt=0.9 Vh=0.2)

* --- velocity storage ---
R_int_L SPIKE_L V_INT_L 10k
C_int_L V_INT_L 0 22u
R_int_R SPIKE_R V_INT_R 10k
C_int_R V_INT_R 0 22u

* --- differential VOR output ---
E_diff VOR_OUT 0 VALUE={V(V_INT_L) - V(V_INT_R)}

.tran 0 3 0 10u
.end
