* [L2] Impact-ionization floating-body latch core (single neuron)
.param Vth0 = 0.45      ; zero body-bias threshold (V)
.param eta  = 0.6       ; body effect: dVth/dV_body
.param nn   = 1.3       ; subthreshold slope factor
.param VT   = 0.0259
.param I0   = 1e-9
.param Ai   = 0.5       ; II multiplication prefactor
.param Bi   = 1.2       ; II critical-field parameter (V)
.param Cb   = 0.5f      ; body capacitance
.param Rb   = 5G        ; body-source recombination -> tau_b (refractory)

VDD VDD 0 1.8
R_load VDD DRAIN 1k
V_gate GATE 0 0.4

* channel current with body-modulated threshold
B_chan DRAIN 0 I = {I0}*exp( min( (V(GATE)-{Vth0}+{eta}*V(BODY))/({nn}*{VT}), 40 ) )

* impact ionization generation current into the floating body
B_ii 0 BODY I = {Ai}*exp( -{Bi}/max(V(DRAIN),1m) ) * I(B_chan)

R_body BODY 0 {Rb}
C_body BODY 0 {Cb}
D_body BODY 0 DBODY        ; body-source junction forward-bias clamp
.model DBODY D(Is=1e-15 N=1)

.ic V(BODY)=0
.options gmin=1e-14 reltol=1e-4 abstol=1e-15 method=gear
.dc V_gate 0 0.8 1m
.end
